* Qucs 25.2.0  C:/Users/Administrator/Desktop/5dd661d7-2556-40dd-b3b7-5f04a688544a/Guitar_Vibrato_Unit_final.sch
.INCLUDE "C:/Program Files/Qucs-S/share/qucs-s/xspice_cmlib/include/ngspice_mathfunc.inc"
V1 _net0 0 DC 0 SIN(0 100M 1K 0 0 0) AC 100M ACPHASE 0
R1 _net0 _net1  1K tc1=0.0 tc2=0.0
R2 0 _net0  100K tc1=0.0 tc2=0.0
B_U1A BUF_DRY 0 V = 1E6*V(_net1,BUF_DRY)*u(15-1E6*V(_net1,BUF_DRY))*u(1E6*V(_net1,BUF_DRY)-(-15))+15*u(1E6*V(_net1,BUF_DRY)-15)+(-15)*u((-15)-1E6*V(_net1,BUF_DRY))
B_U2A WET_OUT 0 V = 1E6*V(_net3,_net2)*u(15-1E6*V(_net3,_net2))*u(1E6*V(_net3,_net2)-(-15))+15*u(1E6*V(_net3,_net2)-15)+(-15)*u((-15)-1E6*V(_net3,_net2))
B_U1B STAGE1_OUT 0 V = 1E6*V(_net5,_net4)*u(15-1E6*V(_net5,_net4))*u(1E6*V(_net5,_net4)-(-15))+15*u(1E6*V(_net5,_net4)-15)+(-15)*u((-15)-1E6*V(_net5,_net4))
C1 BUF_DRY _net5  22N
R3 BUF_DRY _net4  33K tc1=0.0 tc2=0.0
R4 _net4 STAGE1_OUT  33K tc1=0.0 tc2=0.0
C2 STAGE1_OUT _net3  22N
R5 STAGE1_OUT _net2  33K tc1=0.0 tc2=0.0
R6 _net2 WET_OUT  33K tc1=0.0 tc2=0.0
JT2 _net3 _net6 0 JMOD_T2 1.0
.MODEL JMOD_T2 NJF (Vt0=-2.0V Beta=1E-4 Lambda=0.0 Rd=0.0 Rs=0.0 Is=1E-14 Cgs=0.0 Cgd=0.0 Pb=1.0 Fc=0.5 Kf=0.0 Af=1.0 Tcv=0.0 Tnom=26.85 )
JT1 _net5 _net7 0 JMOD_T1 1.0
.MODEL JMOD_T1 NJF (Vt0=-2.0V Beta=1E-4 Lambda=0.0 Rd=0.0 Rs=0.0 Is=1E-14 Cgs=0.0 Cgd=0.0 Pb=1.0 Fc=0.5 Kf=0.0 Af=1.0 Tcv=0.0 Tnom=26.85 )
R7 _net7 _net5  100K tc1=0.0 tc2=0.0
R8 _net3 _net6  100K tc1=0.0 tc2=0.0
R9 _net8 0  33K tc1=0.0 tc2=0.0
R10 _net9 0  33K tc1=0.0 tc2=0.0
R11 MOD_IN 0  560K tc1=0.0 tc2=0.0
R12 MOD_IN 0  560K tc1=0.0 tc2=0.0
V2 BIAS_IN 0 DC -3V
V3 MOD_IN  0 SIN(0 5 5)
R13 OUT _net10  100 tc1=0.0 tc2=0.0
RVR1_1 BUF_DRY _net10 R='(10K)*(120)/(240.0)'
RVR1_2 _net10 WET_OUT R='(10K)*(1.0-(120)/(240.0))'
RTP1_1 0 _net8 R='(10K)*(120)/(240.0)'
RTP1_2 _net8 BIAS_IN R='(10K)*(1.0-(120)/(240.0))'
RTP2_1 0 _net9 R='(10K)*(120)/(240.0)'
RTP2_2 _net9 BIAS_IN R='(10K)*(1.0-(120)/(240.0))'

.control

ac dec 67 20 20k
write spice4qucs.ac1.plot v(BIAS_IN) v(BUF_DRY) v(MOD_IN) v(OUT) v(STAGE1_OUT) v(WET_OUT)
destroy all
reset

tran 1e-05 1 0
write spice4qucs.tr1.plot v(BIAS_IN) v(BUF_DRY) v(MOD_IN) v(OUT) v(STAGE1_OUT) v(WET_OUT)
destroy all
reset

exit
.endc
.END
