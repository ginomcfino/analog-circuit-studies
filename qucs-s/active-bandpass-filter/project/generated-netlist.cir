* Qucs 26.1.1 - active-bandpass-filter.sch

.SUBCKT SpiceOpamp_LM324 	gnd 1 2 3 4 5
*
C1   11 12 5.544E-12
C2    6  7 20.00E-12
DC    5 53 DX
DE   54  5 DX
DLP  90 91 DX
DLN  92 90 DX
DP    4  3 DX
EGND 99  0 POLY(2) (3,0) (4,0) 0 .5 .5
FB    7 99 POLY(5) VB VC VE VLP VLN 0 15.91E6 -20E6 20E6 20E6 -20E6
GA    6  0 11 12 125.7E-6
GCM   0  6 10 99 7.067E-9
IEE   3 10 DC 10.04E-6
HLIM 90  0 VLIM 1K
Q1   11  2 13 QX
Q2   12  1 14 QX
R2    6  9 100.0E3
RC1   4 11 7.957E3
RC2   4 12 7.957E3
RE1  13 10 2.773E3
RE2  14 10 2.773E3
REE  10 99 19.92E6
RO1   8  5 50
RO2   7 99 50
RP    3  4 30.31E3
VB    9  0 DC 0
VC 3 53 DC 2.100
VE   54  4 DC .6
VLIM  7  8 DC 0
VLP  91  0 DC 40
VLN   0 92 DC 40
.MODEL DX D(IS=800.0E-18)
.MODEL QX PNP(IS=800.0E-18 BF=250)
.ENDS

.PARAM VinAmp = 1
XOP1 0 0 _net0 _net1 _net2 VOUT_HP SpiceOpamp_LM324
V2 _net1 0 DC 5
V1 0 _net2 DC 5
R2 _net3 _net0  15.9K tc1=0.0 tc2=0.0
C1 VIN _net3  100N
R1 _net0 VOUT_HP  15.9K tc1=0.0 tc2=0.0
XOP2 0 0 _net4 _net5 _net6 VOUT_LP SpiceOpamp_LM324
V4 _net5 0 DC 5
V5 0 _net6 DC 5
C2 _net4 VOUT_LP  10N
R3 _net4 VOUT_LP  1.59K tc1=0.0 tc2=0.0
R4 VOUT_HP _net4  1.59K tc1=0.0 tc2=0.0
XOP3 0 0 _net7 _net8 _net9 VOUT_HP_2 SpiceOpamp_LM324
V6 _net8 0 DC 5
V7 0 _net9 DC 5
R5 _net10 _net7  15.9K tc1=0.0 tc2=0.0
C3 VOUT_LP _net10  100N
R6 _net7 VOUT_HP_2  15.9K tc1=0.0 tc2=0.0
XOP4 0 0 _net11 _net12 _net13 VOUT_FILTER SpiceOpamp_LM324
V8 _net12 0 DC 5
V9 0 _net13 DC 5
C4 _net11 VOUT_FILTER  10N
R7 _net11 VOUT_FILTER  1.59K tc1=0.0 tc2=0.0
R8 VOUT_HP_2 _net11  1.59K tc1=0.0 tc2=0.0
XOP5 0 0 _net14 _net15 _net16 _net17 SpiceOpamp_LM324
V10 _net15 0 DC 5
V11 0 _net16 DC 5
R9 _net18 _net14  15.9K tc1=0.0 tc2=0.0
C5 VIN_TRAN _net18  100N
R10 _net14 _net17  15.9K tc1=0.0 tc2=0.0
XOP6 0 0 _net19 _net20 _net21 _net22 SpiceOpamp_LM324
V12 _net20 0 DC 5
V13 0 _net21 DC 5
C6 _net19 _net22  10N
R11 _net19 _net22  1.59K tc1=0.0 tc2=0.0
R12 _net17 _net19  1.59K tc1=0.0 tc2=0.0
XOP7 0 0 _net23 _net24 _net25 _net26 SpiceOpamp_LM324
V14 _net24 0 DC 5
V15 0 _net25 DC 5
R13 _net27 _net23  15.9K tc1=0.0 tc2=0.0
C7 _net22 _net27  100N
R14 _net23 _net26  15.9K tc1=0.0 tc2=0.0
XOP8 0 0 _net28 _net29 _net30 VOUT_FILTER_TRAN SpiceOpamp_LM324
V16 _net29 0 DC 5
V17 0 _net30 DC 5
C8 _net28 VOUT_FILTER_TRAN  10N
R15 _net28 VOUT_FILTER_TRAN  1.59K tc1=0.0 tc2=0.0
R16 _net26 _net28  1.59K tc1=0.0 tc2=0.0
V18 VIN_TRAN _net31 DC 0 SIN(0 0.2 10K 0 0 0) AC 0.2 ACPHASE 0
V19 _net31 _net32 DC 0 SIN(0 0.2 1K 0 0 0) AC 0.2 ACPHASE 0
V20 _net32 0 DC 0 SIN(0 0.2 100 0 0 0) AC 0.2 ACPHASE 0
V21 VIN _net33 DC 0 SIN(0 0.2 10K 0 0 0) AC 0.2 ACPHASE 0
V22 _net33 _net34 DC 0 SIN(0 0.2 1K 0 0 0) AC 0.2 ACPHASE 0
V23 _net34 0 DC 0 SIN(0 0.2 100 0 0 0) AC 0.2 ACPHASE 0
XOP9 0 0 _net35 _net36 _net37 _net38 SpiceOpamp_LM324
V24 _net36 0 DC 5
V25 0 _net37 DC 5
R17 _net39 _net35  15.9K tc1=0.0 tc2=0.0
C9 VIN_SW _net39  100N
R18 _net35 _net38  15.9K tc1=0.0 tc2=0.0
XOP10 0 0 _net40 _net41 _net42 _net43 SpiceOpamp_LM324
V26 _net41 0 DC 5
V27 0 _net42 DC 5
C10 _net40 _net43  10N
R19 _net40 _net43  1.59K tc1=0.0 tc2=0.0
R20 _net38 _net40  1.59K tc1=0.0 tc2=0.0
XOP11 0 0 _net44 _net45 _net46 _net47 SpiceOpamp_LM324
V28 _net45 0 DC 5
V29 0 _net46 DC 5
R21 _net48 _net44  15.9K tc1=0.0 tc2=0.0
C11 _net43 _net48  100N
R22 _net44 _net47  15.9K tc1=0.0 tc2=0.0
XOP12 0 0 _net49 _net50 _net51 VOUT_FILTER_SW SpiceOpamp_LM324
V30 0 _net51 DC 5
C12 _net49 VOUT_FILTER_SW  10N
R23 _net49 VOUT_FILTER_SW  1.59K tc1=0.0 tc2=0.0
R24 _net47 _net49  1.59K tc1=0.0 tc2=0.0
V31 VIN_SW 0 DC 0 SIN(0 {VINAMP} 1K 0 0 0) AC {VINAMP} ACPHASE 0
V32 _net50 0 DC 5
R25 VOUT_FILTER_SW VOUT_NORM  1K tc1=0.0 tc2=0.0
D1 0 VOUT_NORM DMOD_D1 AREA=1.0
.MODEL DMOD_D1 D (Is=1E-15 N=1 Cj0=10F M=0.5 Vj=0.7 Fc=0.5 Rs=0.0 Tt=0.0P Kf=0.0 Af=1.0 Bv=10 Ibv=1M Xti=3.0 Eg=1.11 Tcv=0.0 Trs=0.0 Ttt1=0.0 Ttt2=0.0 Tm1=0.0 Tm2=0.0 Tnom=26.85 )
D2 VOUT_NORM 0 DMOD_D2 AREA=1.0
.MODEL DMOD_D2 D (Is=1E-15 N=1 Cj0=10F M=0.5 Vj=0.7 Fc=0.5 Rs=0.0 Tt=0.0P Kf=0.0 Af=1.0 Bv=10 Ibv=1M Xti=3.0 Eg=1.11 Tcv=0.0 Trs=0.0 Ttt1=0.0 Ttt2=0.0 Tm1=0.0 Tm2=0.0 Tnom=26.85 )

.control

ac dec 40 1 100k
write spice4qucs.ac1.plot v(VIN) v(VIN_SW) v(VIN_TRAN) v(VOUT_FILTER) v(VOUT_FILTER_SW) v(VOUT_FILTER_TRAN) v(VOUT_HP) v(VOUT_HP_2) v(VOUT_LP) v(VOUT_NORM)
destroy all
reset

option interp
let number_vinamp = 0
echo "STEP tr1.vinamp" > spice4qucs.tr1.cir.res
foreach  vinamp_act 0.1 0.357895 0.615789 0.873684 1.13158 1.38947 1.64737 1.90526 2.16316 2.42105 2.67895 2.93684 3.19474 3.45263 3.71053 3.96842 4.22632 4.48421 4.74211 5
alterparam VinAmp = $vinamp_act
reset
tran 5e-06 0.1 0
write spice4qucs.tr1._swp.plot v(VIN) v(VIN_SW) v(VIN_TRAN) v(VOUT_FILTER) v(VOUT_FILTER_SW) v(VOUT_FILTER_TRAN) v(VOUT_HP) v(VOUT_HP_2) v(VOUT_LP) v(VOUT_NORM)
set appendwrite
echo "$&number_vinamp  $vinamp_act" >> spice4qucs.tr1.cir.res
let number_vinamp = number_vinamp + 1
end
unset appendwrite
destroy all
reset

exit
.endc
.END
